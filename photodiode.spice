* SPICE3 file created from photodiode.ext - technology: sky130A

D0 GND tap sky130_fd_pr__model__parasitic__diode_ps2dn area=361
C0 Vdd GND 42.907f
C1 tap GND 0.1178f
C2 Vdd GND 72.7774f
